* RC Low Pass Filter
Vin in 0 AC 1
R1 in out 1k
C1 out 0 10uF
.ac dec 10 1 10000
.end
